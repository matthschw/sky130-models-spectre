* Copyright 2020 The SkyWater PDK Authors
*
* Licensed under the Apache License, Version 2.0 (the "License");
* you may not use this file except in compliance with the License.
* You may obtain a copy of the License at
*
*     https://www.apache.org/licenses/LICENSE-2.0
*
* Unless required by applicable law or agreed to in writing, software
* distributed under the License is distributed on an "AS IS" BASIS,
* WITHOUT WARRANTIES OR CONDITIONS OF ANY KIND, either express or implied.
* See the License for the specific language governing permissions and
* limitations under the License.

*********************** SkyWater sky130 model library *************************

library sky130
* Typical corner (tt)
section tt
* MOSFET
include "../cells/nfet_01v8/sky130_fd_pr__nfet_01v8__tt.corner.scs"
include "../cells/pfet_01v8/sky130_fd_pr__pfet_01v8__tt.corner.scs"
include "./corners/tt/nofet.scs"
* Mismatch parameters
include "../cells/nfet_01v8/sky130_fd_pr__nfet_01v8__mismatch.corner.scs"
include "../cells/pfet_01v8/sky130_fd_pr__pfet_01v8__mismatch.corner.scs"
* All models
include "all.scs"
endsection
* Slow-Fast corner (sf)
section sf
* MOSFET
include "../cells/nfet_01v8/sky130_fd_pr__nfet_01v8__sf.corner.scs"
include "../cells/pfet_01v8/sky130_fd_pr__pfet_01v8__sf.corner.scs"
* Mismatch parameters
include "../cells/nfet_01v8/sky130_fd_pr__nfet_01v8__mismatch.corner.scs"
include "../cells/pfet_01v8/sky130_fd_pr__pfet_01v8__mismatch.corner.scs"
* All models
include "all.scs"
endsection
* Fast-Fast corner (ff)
section ff
* MOSFET
include "../cells/nfet_01v8/sky130_fd_pr__nfet_01v8__ff.corner.scs"
include "../cells/pfet_01v8/sky130_fd_pr__pfet_01v8__ff.corner.scs"
* Mismatch parameters
include "../cells/nfet_01v8/sky130_fd_pr__nfet_01v8__mismatch.corner.scs"
include "../cells/pfet_01v8/sky130_fd_pr__pfet_01v8__mismatch.corner.scs"
* All models
include "all.scs"
endsection
* Slow-Slow corner (ss)
section ss
* MOSFET
include "../cells/nfet_01v8/sky130_fd_pr__nfet_01v8__ss.corner.scs"
include "../cells/pfet_01v8/sky130_fd_pr__pfet_01v8__ss.corner.scs"
* Mismatch parameters
include "../cells/nfet_01v8/sky130_fd_pr__nfet_01v8__mismatch.corner.scs"
include "../cells/pfet_01v8/sky130_fd_pr__pfet_01v8__mismatch.corner.scs"
* All models
include "all.scs"
endsection
* Fast-Slow corner (fs)
section fs
* MOSFET
include "../cells/nfet_01v8/sky130_fd_pr__nfet_01v8__fs.corner.scs"
include "../cells/pfet_01v8/sky130_fd_pr__pfet_01v8__fs.corner.scs"
* Mismatch parameters
include "../cells/nfet_01v8/sky130_fd_pr__nfet_01v8__mismatch.corner.scs"
include "../cells/pfet_01v8/sky130_fd_pr__pfet_01v8__mismatch.corner.scs"
* All models
include "all.scs"
endsection
endlibrary
