// technology : Predictive Technology Models (PTM)
// device     : PMOS

simulator lang=spectre
global 0

parameters L=1.65e-07 Vb=0.0 Vg=0.0 Vd=0.0 Vs=0.0 W=2.035e-05 Vdd=1.8

include "./models/sky130.lib.scs" section = tt

save D

M0 (D G S B) sky130_fd_pr__nfet_01v8 m=1 w=W l=L

VD (D S) vsource dc=Vd type=dc
VG (G S) vsource dc=Vg type=dc
VS (S 0) vsource dc=Vs type=dc
VB (B S) vsource dc=Vb type=dc

simulatorOptions options save=selected rawfmt=nutbin

dc dc param=Vg start=Vs stop=Vdd step=0.1
