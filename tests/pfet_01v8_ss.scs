// technology : Skywater PDK
// device     : nfet_01v8

simulator lang=spectre
global 0

parameters L=1.65e-07 Vb=0.0 Vg=0.0 Vd=0.0 Vs=0.0 W=20e-06 Vdd=1.8

include "./../models/sky130.scs" section = ss

save  D G S B                                \
      M0.msky130_fd_pr__pfet_01v8:vds        \
      M0.msky130_fd_pr__pfet_01v8:vgs        \
      M0.msky130_fd_pr__pfet_01v8:vbs        \
      M0.msky130_fd_pr__pfet_01v8:vdsat      \
      M0.msky130_fd_pr__pfet_01v8:vth        \
      M0.msky130_fd_pr__pfet_01v8:gm         \
      M0.msky130_fd_pr__pfet_01v8:id         \
      M0.msky130_fd_pr__pfet_01v8:gds        \
      M0.msky130_fd_pr__pfet_01v8:gmbs       \
      M0.msky130_fd_pr__pfet_01v8:self_gain  \
      M0.msky130_fd_pr__pfet_01v8:fug        \
      M0.msky130_fd_pr__pfet_01v8:gmoverid   \
      M0.msky130_fd_pr__pfet_01v8:cbb        \
      M0.msky130_fd_pr__pfet_01v8:csb        \
      M0.msky130_fd_pr__pfet_01v8:cdb        \
      M0.msky130_fd_pr__pfet_01v8:cgb        \
      M0.msky130_fd_pr__pfet_01v8:css        \
      M0.msky130_fd_pr__pfet_01v8:csd        \
      M0.msky130_fd_pr__pfet_01v8:csg        \
      M0.msky130_fd_pr__pfet_01v8:cds        \
      M0.msky130_fd_pr__pfet_01v8:cdd        \
      M0.msky130_fd_pr__pfet_01v8:cdg        \
      M0.msky130_fd_pr__pfet_01v8:cbs        \
      M0.msky130_fd_pr__pfet_01v8:cbd        \
      M0.msky130_fd_pr__pfet_01v8:cbg        \
      M0.msky130_fd_pr__pfet_01v8:cgd        \
      M0.msky130_fd_pr__pfet_01v8:cgs        \
      M0.msky130_fd_pr__pfet_01v8:cgg        \

M0 (D G S B) sky130_fd_pr__pfet_01v8 m=1 w=W l=L

VD (D S) vsource dc=Vd type=dc
VG (G S) vsource dc=Vg type=dc
VS (S 0) vsource dc=Vs type=dc
VB (B S) vsource dc=Vb type=dc

simulatorOptions options save=selected rawfmt=nutbin

length sweep param=L start=1.5e-07 stop=30u dec=10 {
  bulk sweep param=Vb start=Vs stop=1.0 step=0.2 {
      drain sweep param=Vd start=Vs stop=-Vdd step=-0.1 {
          dc dc param=Vg start=Vs stop=-Vdd step=-0.1
      }
  }
}
